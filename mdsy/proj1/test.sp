* .PARAM VDD = 1 VGS = 1 LN = 0.05U LP = 0.05U WN = 1U WP = 0.5U
* M1 VOUT VIN 0 0 N_50n L = LN W = WN
* M2 VOUT VIN VDD VDD P_50n L = LP W = WP
* C1
.PARAM VDD = 1.8

VOUTSIN VOUT 0 SIN 1.34 1 10

.PRINT V(VOUT)

.lib 'C:\mdsy\rf018.l' TT

.OPTION LIST NODE BRIEF=1
.OPTION POST=3

.END
